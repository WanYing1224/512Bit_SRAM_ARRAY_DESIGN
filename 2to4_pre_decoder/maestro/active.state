ADE simulation setup
Test EE577a_S26_2to4_pre_decoder_1: EE577a_S26/2to4_pre_decoder/schematic, simulator spectre
  Models: /home/ee577@vlab.usc.edu/CDS_GPDK45/gpdk045_v_5_0/gpdk045/../models/spectre/gpdk045.scs[mc]
  Temperature: 27
  Stimulus A0: voltage bit rise=10p fall=10p period=1n data=0110
  Stimulus A1: voltage bit rise=10p fall=10p period=1n data=0011
  Stimulus vdd!: voltage dc dc=1
  Analysis tran: stop=10n errpreset=conservative
  Signals: /A0, /A1, /D0, /D1, /D2, /D3
Run mode: Single Run, Sweeps and Corners
