ADE simulation setup
Run mode: Single Run, Sweeps and Corners
Tests:
  EE577a_S26_2to4_pre_decoder_1: EE577a_S26/2to4_pre_decoder/schematic, simulator spectre
