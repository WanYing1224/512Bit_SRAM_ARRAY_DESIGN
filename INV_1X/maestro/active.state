ADE simulation setup
Test Projects_INV_1X_1: Projects/INV_1X/av_extracted, simulator spectre
  Models: /home/viterbi/01/ee577/CDS_GPDK45/gpdk045_v_5_0/gpdk045/../models/spectre/gpdk045.scs[mc]
  Temperature: 27
  Stimulus vdd!: voltage dc dc=1
  Stimulus IN: voltage bit val1=1 val0=0 rise=10p fall=10p period=1n data=0101010101
  Analysis tran: stop=10n errpreset=conservative
  Signals: /IN, /OUT
Run mode: Single Run, Sweeps and Corners
