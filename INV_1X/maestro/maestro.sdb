ADE simulation setup
Run mode: Single Run, Sweeps and Corners
Tests:
  Projects_INV_1X_1: Projects/INV_1X/av_extracted, simulator spectre
    Outputs: /IN; /OUT
