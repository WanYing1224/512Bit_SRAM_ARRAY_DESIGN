ADE simulation setup
Test Projects_DFF_RST_1: Projects/DFF_RST/schematic, simulator spectre
  Models: /home/viterbi/01/ee577/CDS_GPDK45/gpdk045_v_5_0/gpdk045/../models/spectre/gpdk045.scs[mc]
  Temperature: 27
  Stimulus D: voltage bit val1=1 val0=0 rise=10p fall=10p period=1n data=00000011001111001100
  Stimulus RST_B: voltage bit val1=1 val0=0 rise=10p fall=10p period=1n data=11001111001100110011
  Stimulus CLK: voltage bit val1=1 val0=0 rise=10p fall=10p period=1n data=01010101010101010101
  Stimulus vdd!: voltage dc dc=1
  Analysis tran: stop=20n errpreset=conservative
  Signals: /D, /CLK, /Q, /Q_B, /RST_B
Run mode: Single Run, Sweeps and Corners
