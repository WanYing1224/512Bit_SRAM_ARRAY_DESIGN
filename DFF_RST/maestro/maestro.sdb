ADE simulation setup
Run mode: Single Run, Sweeps and Corners
Tests:
  Projects_DFF_RST_1: Projects/DFF_RST/schematic, simulator spectre
    Outputs: /D; /CLK; /Q; /Q_B; /RST_B
