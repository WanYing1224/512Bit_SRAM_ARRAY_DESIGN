ADE simulation setup
Test EE577a_S26_512bit_SRAM_Array_1: EE577a_S26/512bit_SRAM_Array/schematic, simulator spectre
  Models: /home/ee577@vlab.usc.edu/CDS_GPDK45/gpdk045_v_5_0/gpdk045/../models/spectre/gpdk045.scs[mc]
  Temperature: 27
  Files: vectors /home/yluo4810@vlab.usc.edu/work_gpdk045/EE577a_S26/512bit_SRAM_Array/sram_512bit_final1.vec
  Stimulus VSS!: voltage dc dc=0
  Stimulus vdd!: voltage dc dc=1
  Stimulus VDD!: voltage dc dc=1
  Stimulus clk: voltage pulse dc=1 val0=0 val1=1 period=1n rise=5p fall=5p width=500.0p
  Analysis tran: stop=145n
  Signals: /precharge_en, /A<4:0>, /A_bar<4:0>, /clk, /decoder_en, /write_en, /data_in<15:0>, /read_en, /sense_en, /precharge_en_SA, /rst, /data_out<15:0>, /out1<15:0>, /out2<15:0>, /Dout<4:2>, /Dout_b<4:2>, /Dout<1:0>, /Dout_b<1:0>
Run mode: Single Run, Sweeps and Corners
