ADE simulation setup
Test EE577a_S26_512bit_SRAM_Array_1: EE577a_S26/512bit_SRAM_Array/schematic, simulator spectre
  Models: /home/ee577@vlab.usc.edu/CDS_GPDK45/gpdk045_v_5_0/gpdk045/../models/spectre/gpdk045.scs[mc]
  Temperature: 27
  Files: vectors /home/linwanyi@vlab.usc.edu/work_gpdk045/EE577a_S26/512bit_SRAM_Array/sram_512bit_final1.vec
  Stimulus VSS!: voltage dc dc=0
  Stimulus VDD!: voltage dc dc=1
  Stimulus vdd!: voltage dc dc=1
  Analysis tran: stop=145n
  Signals: /precharge_en, /A<4:0>, /A_bar<4:0>, /clk, /decoder_en, /write_en, /data_in<15:0>, /read_en, /sense_en, /precharge_en_SA, /rst, /data_out<15:0>
Run mode: Single Run, Sweeps and Corners
