ADE simulation setup
Run mode: Single Run, Sweeps and Corners
Tests:
  EE577a_S26_512bit_SRAM_Array_1: EE577a_S26/512bit_SRAM_Array/schematic, simulator spectre
    Outputs: /out2<15:0>
