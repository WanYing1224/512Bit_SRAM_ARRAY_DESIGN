ADE simulation setup
Run mode: Single Run, Sweeps and Corners
Tests:
  EE577a_S26_512bit_SRAM_Array_1: EE577a_S26/512bit_SRAM_Array/schematic, simulator spectre
    Outputs: /Aout<4:0>; /About<4:0>; /Aout<4:2>; /About<4:2>; /Aout<1:0>; /About<1:0>
