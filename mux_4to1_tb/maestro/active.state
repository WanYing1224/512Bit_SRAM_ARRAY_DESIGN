ADE simulation setup
Test EE577a_S26_mux_4to1_tb_1: EE577a_S26/mux_4to1_tb/schematic, simulator spectre
  Models: /home/ee577@vlab.usc.edu/CDS_GPDK45/gpdk045_v_5_0/gpdk045/../models/spectre/gpdk045.scs[mc]
  Temperature: 27
  Stimulus vdd!: voltage dc dc=1
  Stimulus CS0: voltage pulse dc=1 val0=0 val1=1 period=8n delay=0 rise=10p fall=10p width=2n
  Stimulus CS1: voltage pulse dc=1 val0=0 val1=1 period=8n delay=2n rise=10p fall=10p width=2n
  Stimulus CS2: voltage pulse dc=1 val0=0 val1=1 period=8n delay=4n rise=10p fall=10p width=2n
  Stimulus CS3: voltage pulse dc=1 val0=0 val1=1 period=8n delay=6n rise=10p fall=10p width=2n
  Stimulus vdd: voltage dc dc=1
  Stimulus gnd: voltage dc dc=0
  Analysis tran: stop=16n
  Signals: /BL0, /BL1, /BL2, /BL3, /Sense
Run mode: Single Run, Sweeps and Corners
