ADE simulation setup
Run mode: Single Run, Sweeps and Corners
Tests:
  EE577a_S26_mux_4to1_tb_1: EE577a_S26/mux_4to1_tb/schematic, simulator spectre
