ADE simulation setup
Test EE577a_F25_SRAM_test_prelab_1: EE577a_S26/SRAM_test_prelab/schematic, simulator spectre
  Models: /home/viterbi/01/ee577/CDS_GPDK45/gpdk045_v_5_0/gpdk045/../models/spectre/gpdk045.scs[mc]
  Temperature: 27
  Files: vectors /home/viterbi/07/kopur/work_gpdk045/EE577a_F25/SRAM_test_prelab/prelab_6t_test.vec
  Stimulus vdd!: voltage dc dc=1
  Analysis tran: stop=19n
  Signals: /write_enable, /write_data, /word_line, /pre_en, /read_en, /pre_en_SA, /sense_en, /CS0, /CS1, /Q, /d1, /d0, /BL1, /BLB1
Test EE577a_S26_SRAM_test_prelab_1: EE577a_S26/SRAM_test_prelab/schematic, simulator spectre
  Models: /home/ee577@vlab.usc.edu/CDS_GPDK45/gpdk045_v_5_0/gpdk045/../models/spectre/gpdk045.scs[mc]
  Temperature: 27
  Files: vectors /home/kopur@vlab.usc.edu/work_gpdk045/EE577a_S26/SRAM_test_prelab/prelab_6t_test.vec
  Stimulus vdd!: voltage dc dc=1
  Analysis tran: stop=19n
  Signals: /write_enable, /write_data, /word_line, /pre_en, /read_en, /pre_en_SA, /sense_en, /CS0, /CS1, /Q, /d1, /d0, /BL1, /BLB1
