ADE simulation setup
Run mode: Single Run, Sweeps and Corners
Tests:
  EE577a_S26_SRAM_test_prelab_1: EE577a_S26/SRAM_test_prelab/schematic, simulator spectre
