ADE simulation setup
Run mode: Single Run, Sweeps and Corners
Tests:
  EE577a_S26_SRAM_1bit_test_1: EE577a_S26/SRAM_1bit_test/schematic, simulator spectre
