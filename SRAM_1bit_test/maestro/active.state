ADE simulation setup
Test EE577a_S26_SRAM_1bit_test_1: EE577a_S26/SRAM_1bit_test/schematic, simulator spectre
  Models: /home/ee577@vlab.usc.edu/CDS_GPDK45/gpdk045_v_5_0/gpdk045/../models/spectre/gpdk045.scs[mc]
  Temperature: 27
  Files: vectors /home/yluo4810@vlab.usc.edu/work_gpdk045/EE577a_S26/SRAM_1bit_test/sram_1bit_test_1.vec
  Stimulus VSS!: voltage dc dc=0
  Stimulus VDD!: voltage dc dc=1
  Stimulus vdd!: voltage dc dc=1
  Analysis tran: stop=19n
  Signals: /word_line, /pre_en, /write_enable, /write_data, /read_en, /pre_en_SA, /sense_en, /Q, /d0, /BL
Run mode: Single Run, Sweeps and Corners
