ADE simulation setup
Test EE577a_S26_3to8_Row_Decoder_1: EE577a_S26/3to8_Row_Decoder/schematic, simulator spectre
  Models: /home/ee577@vlab.usc.edu/CDS_GPDK45/gpdk045_v_5_0/gpdk045/../models/spectre/gpdk045.scs[mc]
  Temperature: 27
  Stimulus VSS!: voltage dc dc=0
  Stimulus VDD!: voltage dc dc=1
  Stimulus A_bar<2>: voltage bit rise=5p fall=5p period=1n data=11110000
  Stimulus A_bar<1>: voltage bit rise=5p fall=5p period=1n data=11001100
  Stimulus A_bar<0>: voltage bit rise=5p fall=5p period=1n data=10101010
  Stimulus Decoder_EN: voltage dc dc=1
  Stimulus VSS: voltage dc dc=0
  Stimulus VDD: voltage dc dc=1
  Stimulus A<2>: voltage bit rise=5p fall=5p period=1n data=00001111
  Stimulus A<1>: voltage bit rise=5p fall=5p period=1n data=00110011
  Stimulus A<0>: voltage bit rise=5p fall=5p period=1n data=01010101
  Analysis tran: stop=9n
  Signals: /A<2:0>, /A_bar<2:0>, /Decoder_EN, /WL<7:0>
