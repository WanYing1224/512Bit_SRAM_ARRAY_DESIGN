ADE simulation setup
Run mode: Single Run, Sweeps and Corners
Tests:
  Projects_DFF_1: Projects/DFF/schematic, simulator spectre
    Outputs: /D; /CLK; "/"; /Q_B; /; /Q
