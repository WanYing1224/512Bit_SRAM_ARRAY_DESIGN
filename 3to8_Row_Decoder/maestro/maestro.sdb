ADE simulation setup
Run mode: Single Run, Sweeps and Corners
Tests:
  EE577a_S26_3to8_Row_Decoder_1: EE577a_S26/3to8_Row_Decoder/schematic, simulator spectre
