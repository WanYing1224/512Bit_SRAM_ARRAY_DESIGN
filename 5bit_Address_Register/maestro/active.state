ADE simulation setup
Test EE577a_S26_5bit_Address_Register_1: EE577a_S26/5bit_Address_Register/schematic, simulator spectre
  Models: /home/ee577@vlab.usc.edu/CDS_GPDK45/gpdk045_v_5_0/gpdk045/../models/spectre/gpdk045.scs[mc]
  Temperature: 27
  Stimulus vdd!: voltage dc dc=1
  Stimulus VSS!: voltage dc dc=0
  Stimulus VDD!: voltage dc dc=1
  Stimulus ADDR_IN<4>: voltage bit rise=5p fall=5p period=1n data=101010
  Stimulus ADDR_IN<3>: voltage bit rise=5p fall=5p period=1n data=101010
  Stimulus ADDR_IN<2>: voltage bit rise=5p fall=5p period=1n data=101010
  Stimulus ADDR_IN<1>: voltage bit rise=5p fall=5p period=1n data=101010
  Stimulus ADDR_IN<0>: voltage bit rise=5p fall=5p period=1n data=101010
  Stimulus CLK: voltage pulse dc=1 val0=0 val1=1 period=500p delay=250p rise=5p fall=5p width=250p
  Stimulus ADDR_IN_bar<4>: voltage bit rise=5p fall=5p period=1n data=010101
  Stimulus ADDR_IN_bar<3>: voltage bit rise=5p fall=5p period=1n data=010101
  Stimulus ADDR_IN_bar<2>: voltage bit rise=5p fall=5p period=1n data=010101
  Stimulus ADDR_IN_bar<1>: voltage bit rise=5p fall=5p period=1n data=010101
  Stimulus ADDR_IN_bar<0>: voltage bit rise=5p fall=5p period=1n data=010101
  Analysis tran: stop=7n
  Signals: /ADDR_IN<4:0>, /ADDR_IN_bar<4:0>, /CLK, /A<4:0>, /A_bar<4:0>
