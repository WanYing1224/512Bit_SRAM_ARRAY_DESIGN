ADE simulation setup
Run mode: Single Run, Sweeps and Corners
Tests:
  EE577a_S26_5bit_Address_Register_1: EE577a_S26/5bit_Address_Register/schematic, simulator spectre
    Outputs: /ADDR_IN<4:0>
