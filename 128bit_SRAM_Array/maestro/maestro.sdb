ADE simulation setup
Run mode: Single Run, Sweeps and Corners
Tests:
  EE577a_S26_128bit_SRAM_Array_1: EE577a_S26/128bit_SRAM_Array/schematic, simulator spectre
