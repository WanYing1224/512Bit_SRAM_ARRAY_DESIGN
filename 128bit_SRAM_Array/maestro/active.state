ADE simulation setup
Test EE577a_S26_128bit_SRAM_Array_1: EE577a_S26/128bit_SRAM_Array/schematic, simulator spectre
  Models: /home/ee577@vlab.usc.edu/CDS_GPDK45/gpdk045_v_5_0/gpdk045/../models/spectre/gpdk045.scs[mc]
  Temperature: 27
  Files: vectors /home/yluo4810@vlab.usc.edu/work_gpdk045/EE577a_S26/128bit_SRAM_Array/lab4_128bit_SRAM_test.vec
  Stimulus VDD!: voltage dc dc=1
  Stimulus VSS!: voltage dc dc=0
  Stimulus VSS: voltage dc dc=0
  Stimulus VDD: voltage dc dc=1
  Analysis tran: stop=143n
  Signals: /pre_en, /aa<4:0>, /aab<4:0>, /column_dec_en, /read_en, /sense_en, /pre_en_SA, /write_en, /decoder_en, /Q<3:0>, /QB<3:0>, /cs0, /cs2, /cs3, /w3, /w2, /w1, /w0, /bl<15:0>, /blb<15:0>
Run mode: Single Run, Sweeps and Corners
