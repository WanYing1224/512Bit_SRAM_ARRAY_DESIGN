ADE simulation setup
Test Projects_AND2_1X_1: Projects/AND2_1X/schematic, simulator spectre
  Models: /home/viterbi/01/ee577/CDS_GPDK45/gpdk045_v_5_0/gpdk045/../models/spectre/gpdk045.scs[mc]
  Temperature: 27
  Stimulus A: voltage bit val1=1 val0=0 rise=10p fall=10p period=1n data=0011
  Stimulus B: voltage bit val1=1 val0=0 rise=10p fall=10p period=1n data=0110
  Stimulus vdd!: voltage dc dc=1
  Analysis tran: stop=10n errpreset=conservative
  Signals: /A, /B, /OUT
Run mode: Single Run, Sweeps and Corners
