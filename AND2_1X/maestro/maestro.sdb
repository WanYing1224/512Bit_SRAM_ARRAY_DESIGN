ADE simulation setup
Run mode: Single Run, Sweeps and Corners
Tests:
  Projects_AND2_1X_1: Projects/AND2_1X/schematic, simulator spectre
    Outputs: /A; /B; /OUT
